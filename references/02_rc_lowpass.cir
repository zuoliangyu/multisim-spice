RC low-pass filter - AC sweep
* fc = 1 / (2*pi*R*C) = 1 / (2*pi*1.59k*100n) = 1.00 kHz
V1 in 0 DC 0 AC 1
R1 in out 1.59k
C1 out 0 100n
.ac dec 100 10 100k
.end
