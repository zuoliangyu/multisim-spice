Several semiconductor models in one circuit - DC operating point
* Demonstrates the Multisim model write-back (scripts/patch-ms14.ps1): two NPN models, one PNP,
* two diode models, D1 and D3 sharing one. Each device has its own bias network, so its
* operating point shows which model it ended up with.
VCC vcc 0 DC 12
RB1 vcc b1 1meg
RC1 vcc c1 2k
Q1 c1 b1 0 Q2N2222
RB2 vcc b2 1meg
RC2 vcc c2 4.7k
Q2 c2 b2 0 QHIBETA
RB3 b3 0 1meg
RC3 c3 0 2k
Q3 c3 b3 vcc Q2N3906
V2 a 0 DC 5
RD1 a d1 1k
D1 d1 0 D1N4148
RD2 a d2 1k
D2 d2 0 D1N4007
RD3 a d3 10k
D3 d3 0 D1N4148
.model Q2N2222 NPN(IS=14.34f XTI=3 EG=1.11 VAF=74.03 BF=255.9 NE=1.307 ISE=14.34f IKF=0.2847 XTB=1.5 BR=6.092 NC=2 ISC=0 IKR=0 RC=1 CJC=7.306p MJC=0.3416 VJC=0.75 FC=0.5 CJE=22.01p MJE=0.377 VJE=0.75 TR=46.91n TF=411.1p ITF=0.6 VTF=1.7 XTF=3 RB=10)
.model QHIBETA NPN(IS=14.34f BF=500 VAF=74.03 IKF=0.2847 ISE=14.34f NE=1.307)
.model Q2N3906 PNP(IS=1.41f XTI=3 EG=1.11 VAF=18.7 BF=180.7 NE=1.5 ISE=0 IKF=80m XTB=1.5 BR=4.977 NC=2 ISC=0 IKR=0 RC=2.5 CJC=9.728p MJC=0.5776 VJC=0.75 FC=0.5 CJE=8.063p MJE=0.3677 VJE=0.75 TR=33.42n TF=179.3p ITF=0.4 VTF=4 XTF=6 RB=10)
.model D1N4148 D(IS=2.52n RS=0.568 N=1.752 CJO=4p M=0.4 TT=20n BV=100 IBV=100u)
.model D1N4007 D(IS=7.02767n RS=0.0341512 N=1.80803 EG=1.05743 XTI=5 BV=1000 IBV=0.1 CJO=10p VJ=0.7 M=0.5 FC=0.5 TT=100n)
.op
.end
